Stereo Line In B - functional circuit verification
VPLUS VP 0 11.6
VMINUS VN 0 -11.6
VSRC SRC 0 SIN(0 7.759 1000)
VREF VREF 0 2.495
VLED VLED 0 11.2
.options method=gear
.model DGEN D(Is=1e-12 N=1 Rs=1)

.subckt OP P N O
EGAIN DRIVER 0 P N 100k
RDOM DRIVER DOM 1Meg
CDOM DOM 0 1n
VCP CP 0 10
VCN CN 0 -10
DCP DOM CP DGEN
DCN CN DOM DGEN
BOUT O 0 V=max(-10.6,min(10.6,V(DOM)))
.ends OP
R_TH_TOP_1 VREF TH_1 240k
R_TH_BOTTOM_1 TH_1 0 10k
R_TH_TOP_2 VREF TH_2 52.3k
R_TH_BOTTOM_2 TH_2 0 10k
R_TH_TOP_3 VREF TH_3 15k
R_TH_BOTTOM_3 TH_3 0 10k
R_TH_TOP_4 VREF TH_4 5.62k
R_TH_BOTTOM_4 TH_4 0 10k
C_L_VP VP 0 100n
C_L_VN 0 VN 100n
R_L_WIPER_FAIL L_WIPER 0 1Meg
R_L_GAIN_G L_GAIN_FB 0 10k
R_L_GAIN_F L_DRIVE L_GAIN_FB 90k
C_L_GAIN_F L_DRIVE L_GAIN_FB 10p
R_L_OUT L_DRIVE L_OUT 100
R_L_OUT_BLEED L_OUT 0 1Meg
R_L_HALF_IN L_OUT L_HALF_SUM 100k
R_L_HALF_FB L_HALF L_HALF_SUM 100k
D_L_HALF_CLAMP L_HALF_DRIVE L_HALF_SUM DGEN
D_L_HALF_RECT L_HALF L_HALF_DRIVE DGEN
R_L_ABS_RAW L_OUT L_ABS_SUM 100k
R_L_ABS_HALF L_HALF L_ABS_SUM 50k
R_L_ABS_FB L_ABS L_ABS_SUM 20k
D_L_PEAK L_PEAK_DRIVE L_PEAK_FOLLOW DGEN
R_L_ATTACK L_PEAK_FOLLOW L_ENV 1k
C_L_HOLD L_ENV 0 100n
R_L_RELEASE L_ENV 0 1Meg
B_P L_TIP 0 V=0.5*V(SRC)
R_L_P_BLEED L_TIP 0 1Meg
R_L_P_SERIES L_TIP L_P_SERIES 1k
C_L_P_AC L_P_SERIES L_RX_P 1u
R_RX_BIAS_P L_RX_P 0 500k
B_N L_RING 0 V=-0.5*V(SRC)
R_L_N_BLEED L_RING 0 1Meg
R_L_N_SERIES L_RING L_N_SERIES 1k
C_L_N_AC L_N_SERIES L_RX_N 1u
R_RX_BIAS_N L_RX_N 0 500k
B_RX L_RX_OUT 0 V=max(-10.2,min(10.2,V(L_RX_P,L_RX_N)))
R_POT_TOP L_RX_OUT L_WIPER 9355
R_POT_BOTTOM L_WIPER 0 645
R_LOAD L_OUT 0 100k
XA L_WIPER L_GAIN_FB L_DRIVE OP
XB 0 L_HALF_SUM L_HALF_DRIVE OP
XC 0 L_ABS_SUM L_ABS OP
XD L_ABS L_PEAK_FOLLOW L_PEAK_DRIVE OP
XENV L_ENV L_ENV_BUF L_ENV_BUF OP
I_CMP_BIAS 0 L_ENV_BUF 100n
.tran 2u 15m 0 2u
.save v(SRC) v(L_OUT) v(L_HALF) v(L_ABS) v(L_ENV)
.end
